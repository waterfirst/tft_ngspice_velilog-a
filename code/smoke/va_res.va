`include "constants.vams"
`include "disciplines.vams"
module va_res(p, n);
  inout p, n;
  electrical p, n;
  parameter real R = 1e3 from (0:inf);
  analog I(p, n) <+ V(p, n) / R;
endmodule
